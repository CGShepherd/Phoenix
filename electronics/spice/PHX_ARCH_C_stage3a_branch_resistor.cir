* Project Phoenix - Architecture C Stage 3A branch-series-resistor sweep
* Purpose: quantify normal-operation penalty of a small resistor in series with
* each preregulator pass-transistor collector feed.
*
* Baseline RZ = 3.6k, BF=15, TI regulator models.
* Sweep RBRANCH = 0 / 47 / 68 / 100 ohm at the established worst low-line/high-load
* voltage corners.

.param VRAW=48
.param RIPPLE=2
.param FLINE=100
.param ILOAD=10m
.param RZ=3.6k
.param CZ=47u
.param VZ=22.8
.param BFBJT=15
.param RBR=0

VRAW_P rawp 0 SINE({VRAW} {RIPPLE} {FLINE})
VRAW_N rawn 0 SINE({-VRAW} {RIPPLE} {FLINE})

RBP rawp cp {RBR}
RBN rawn cn {RBR}

RZP rawp zbp {RZ}
DZP 0 zbp DZ24
CZP zbp 0 {CZ}
QPASS_P cp zbp prep TIP41C_BOUNDED

RZN rawn zbn {RZ}
DZN zbn 0 DZ24
CZN zbn 0 {CZ}
QPASS_N cn zbn pren TIP42C_BOUNDED

VSENSEP prep reginp 0
VSENSEN pren reginn 0
R1P outp adjp 120
R2P adjp 0 1.50k
R1N outn adjn 120
R2N adjn 0 1.50k
COUTP outp 0 10u
COUTN 0 outn 10u
IP_LOAD outp 0 {ILOAD}
IN_LOAD 0 outn {ILOAD}

.include "models/ti/ltspice/LM317_TRANS_LTSPICE.LIB"
.include "models/ti/ltspice/LM337_N_TRANS_LTSPICE.LIB"
XU317 reginp adjp outp nc317 LM317_TRANS
XU337 reginn adjn outn LM337_N_TRANS

.model DZ24 D(BV={VZ} IBV=5m RS=1 N=1.2 CJO=200p)
.model TIP41C_BOUNDED NPN(IS=1e-12 BF={BFBJT} VAF=75 IKF=1 CJE=300p CJC=150p)
.model TIP42C_BOUNDED PNP(IS=1e-12 BF={BFBJT} VAF=75 IKF=1 CJE=300p CJC=150p)

.step param RBR list 0.01 47 68 100
.step param VZ list 22.8 24 25.6

.tran 0 300m 0 20u startup

.meas TRAN PREP_AVG AVG V(prep) FROM 250m TO 300m
.meas TRAN OUTP_AVG AVG V(outp) FROM 250m TO 300m
.meas TRAN DROP_P_MIN MIN V(prep,outp) FROM 250m TO 300m
.meas TRAN IBRP_AVG AVG I(RBP) FROM 250m TO 300m
.meas TRAN PBRP_AVG AVG V(rawp,cp)*I(RBP) FROM 250m TO 300m
.meas TRAN PQP_AVG AVG V(cp,prep)*Ic(QPASS_P) FROM 250m TO 300m

.end
