* Project Phoenix - Architecture C Stage 3 batch verification
* Requires locally prepared TI LTspice compatibility libraries:
*   models/ti/ltspice/LM317_TRANS_LTSPICE.LIB
*   models/ti/ltspice/LM337_N_TRANS_LTSPICE.LIB

* TEST 00: normal-operation protection margin including fuse cold resistance.
.param VRAW=55 RIPPLE=2 FLINE=100 ILOAD=4.7m VZ=24
.param RZ=3.6k CZ=47u BFBJT=15
.param RFUSE=5.5 RBR=100

VRAW_P srcp 0 SINE({VRAW} {RIPPLE} {FLINE})
VRAW_N srcn 0 SINE({-VRAW} {RIPPLE} {FLINE})
RFUSEP srcp rawp {RFUSE}
RFUSEN srcn rawn {RFUSE}
RBRP rawp cp {RBR}
RBRN rawn cn {RBR}

RZP cp zbp {RZ}
DZP 0 zbp DZ24
CZP zbp 0 {CZ}
QPASS_P cp zbp prep TIP41C_BOUNDED
RZN cn zbn {RZ}
DZN zbn 0 DZ24
CZN zbn 0 {CZ}
QPASS_N cn zbn pren TIP42C_BOUNDED

VSENSEP prep reginp 0
VSENSEN pren reginn 0
R1P outp adjp 120
R2P adjp 0 1.50k
R1N outn adjn 120
R2N adjn 0 1.50k
COUTP outp 0 10u
COUTN 0 outn 10u
IP_LOAD outp 0 {ILOAD}
IN_LOAD 0 outn {ILOAD}

.include "models/ti/ltspice/LM317_TRANS_LTSPICE.LIB"
.include "models/ti/ltspice/LM337_N_TRANS_LTSPICE.LIB"
XU317 reginp adjp outp nc317 LM317_TRANS
XU337 reginn adjn outn LM337_N_TRANS

.model DZ24 D(BV={VZ} IBV=5m RS=1 N=1.2 CJO=200p)
.model TIP41C_BOUNDED NPN(IS=1e-12 BF={BFBJT} VAF=75 IKF=1 CJE=300p CJC=150p)
.model TIP42C_BOUNDED PNP(IS=1e-12 BF={BFBJT} VAF=75 IKF=1 CJE=300p CJC=150p)

.step param VRAW list 48 55 60
.step param ILOAD list 0 4.7m 10m
.step param VZ list 22.8 24 25.6
.tran 0 220m 0 25u startup

.meas TRAN REGINP_MAX MAX V(reginp) FROM 170m TO 220m
.meas TRAN REGINN_MAG_MAX MAX -V(reginn) FROM 170m TO 220m
.meas TRAN OUTP_AVG AVG V(outp) FROM 170m TO 220m
.meas TRAN OUTN_AVG AVG V(outn) FROM 170m TO 220m
.meas TRAN FUSEP_I_AVG AVG I(RFUSEP) FROM 170m TO 220m
.meas TRAN FUSEP_P_AVG AVG V(srcp,rawp)*I(RFUSEP) FROM 170m TO 220m
.meas TRAN RBRP_P_AVG AVG V(rawp,cp)*I(RBRP) FROM 170m TO 220m
.end
