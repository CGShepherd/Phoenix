* Project Phoenix - Architecture C Stage 3 batch verification
* Requires locally prepared TI LTspice compatibility libraries:
*   models/ti/ltspice/LM317_TRANS_LTSPICE.LIB
*   models/ti/ltspice/LM337_N_TRANS_LTSPICE.LIB

* TEST 04: startup and shutdown of both rails at 60 V endpoint.
.param ILOAD=10m RFUSE=5.5 RBR=100
VRAW_P srcp 0 PWL(0 0 20m 60 180m 60 220m 0 300m 0)
VRAW_N srcn 0 PWL(0 0 20m -60 180m -60 220m 0 300m 0)
RFUSEP srcp rawp {RFUSE}
RFUSEN srcn rawn {RFUSE}
RBRP rawp cp {RBR}
RBRN rawn cn {RBR}
RZP cp zbp 3.6k
DZP 0 zbp DZ24
CZP zbp 0 47u
QPASS_P cp zbp prep TIP41C_BOUNDED
RZN cn zbn 3.6k
DZN zbn 0 DZ24
CZN zbn 0 47u
QPASS_N cn zbn pren TIP42C_BOUNDED

R1P outp adjp 120
R2P adjp 0 1.50k
R1N outn adjn 120
R2N adjn 0 1.50k
COUTP outp 0 10u
COUTN 0 outn 10u
IP outp 0 {ILOAD}
IN 0 outn {ILOAD}

.include "models/ti/ltspice/LM317_TRANS_LTSPICE.LIB"
.include "models/ti/ltspice/LM337_N_TRANS_LTSPICE.LIB"
XUP prep adjp outp nc317 LM317_TRANS
XUN pren adjn outn LM337_N_TRANS

.model DZ24 D(BV=24 IBV=5m RS=1 N=1.2 CJO=200p)
.model TIP41C_BOUNDED NPN(IS=1e-12 BF=15 VAF=75 IKF=1 CJE=300p CJC=150p)
.model TIP42C_BOUNDED PNP(IS=1e-12 BF=15 VAF=75 IKF=1 CJE=300p CJC=150p)

.tran 0 300m 0 5u startup
.meas TRAN OUTP_MAX MAX V(outp) FROM 0 TO 80m
.meas TRAN OUTP_MIN MIN V(outp) FROM 0 TO 80m
.meas TRAN OUTN_MAX MAX V(outn) FROM 0 TO 80m
.meas TRAN OUTN_MIN MIN V(outn) FROM 0 TO 80m
.meas TRAN PREP_MAX MAX V(prep) FROM 0 TO 80m
.meas TRAN PREN_MIN MIN V(pren) FROM 0 TO 80m
.meas TRAN SHUT_OUTP_MAX MAX V(outp) FROM 180m TO 300m
.meas TRAN SHUT_OUTN_MIN MIN V(outn) FROM 180m TO 300m
.end
