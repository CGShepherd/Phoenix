* Project Phoenix - Architecture C Stage 2C high-line thermal sweep
* Purpose: bound RZ and Zener dissipation at VRAW=60 V / zero external load
*          with hot effective BZX55C24 voltage.
*
* Effective VZ uses typical TCVZ=7.5e-4 /K. This is sensitivity evidence.

.param VRAW=60
.param RIPPLE=2
.param FLINE=100
.param ILOAD=0
.param RZ=3.6k
.param CZ=47u
.param VZ25=24
.param TDEV=25
.param TCVZ=7.5e-4
.param VZEFF={VZ25*(1+TCVZ*(TDEV-25))}
.param BFBJT=15

VRAW_P rawp 0 SINE({VRAW} {RIPPLE} {FLINE})
VRAW_N rawn 0 SINE({-VRAW} {RIPPLE} {FLINE})

RZP rawp zbp {RZ}
DZP 0 zbp DZ24
CZP zbp 0 {CZ}
QPASS_P rawp zbp prep TIP41C_BOUNDED
RZN rawn zbn {RZ}
DZN zbn 0 DZ24
CZN zbn 0 {CZ}
QPASS_N rawn zbn pren TIP42C_BOUNDED

VSENSEP prep reginp 0
VSENSEN pren reginn 0
R1P outp adjp 120
R2P adjp 0 1.50k
R1N outn adjn 120
R2N adjn 0 1.50k
COUTP outp 0 10u
COUTN 0 outn 10u
IP_LOAD outp 0 {ILOAD}
IN_LOAD 0 outn {ILOAD}

.include "models/ti/ltspice/LM317_TRANS_LTSPICE.LIB"
.include "models/ti/ltspice/LM337_N_TRANS_LTSPICE.LIB"
XU317 reginp adjp outp nc317 LM317_TRANS
XU337 reginn adjn outn LM337_N_TRANS

.model DZ24 D(BV={VZEFF} IBV=5m RS=1 N=1.2 CJO=200p)
.model TIP41C_BOUNDED NPN(IS=1e-12 BF={BFBJT} VAF=75 IKF=1 CJE=300p CJC=150p)
.model TIP42C_BOUNDED PNP(IS=1e-12 BF={BFBJT} VAF=75 IKF=1 CJE=300p CJC=150p)

.step param RZ list 3.6k 3.3k
.step param VZ25 list 22.8 24 25.6
.step param TDEV list 25 60 85

.tran 0 300m 0 20u startup

.meas TRAN VZEFF_CALC PARAM VZEFF
.meas TRAN IZP_AVG AVG -I(DZP) FROM 250m TO 300m
.meas TRAN IRZP_AVG AVG I(RZP) FROM 250m TO 300m
.meas TRAN PRZP_AVG AVG V(rawp,zbp)*I(RZP) FROM 250m TO 300m
.meas TRAN PZP_AVG AVG V(zbp)*(-I(DZP)) FROM 250m TO 300m
.meas TRAN PQP_AVG AVG V(rawp,prep)*Ic(QPASS_P) FROM 250m TO 300m
.meas TRAN PQN_AVG AVG V(pren,rawn)*(-Ic(QPASS_N)) FROM 250m TO 300m

.end
