* Project Phoenix - Architecture C Stage 3D TVS clamp integration
* TVS model is a conservative linearized SMBJ30A approximation:
*   BV(max) = 36.8 V at ~1 mA
*   RS = (48.4-36.8)/(12.4-0.001) = 0.9356 ohm
* Source impedance includes 5.5 ohm fuse + 100 ohm branch resistor.

* TEST 03: fuse I2t if TVS acts before/without SCR.
.param VRAW=60 RBR=100 RFUSE=5.5

VRAW src 0 {VRAW}
RF src raw {RFUSE}
VS raw sense 0
RB sense reg {RBR}
DTVS 0 reg TVS
.model TVS D(BV=36.8 IBV=1m RS=0.9356 N=1 CJO=500p)

.step param VRAW list 48 55 60 62
.tran 0 20m 0 1u

BISQ isq 0 V={I(VS)^2}
BPTVS ptvs 0 V={V(reg)*(-I(DTVS))}
BPR pr 0 V={V(sense,reg)*I(VS)}

.meas TRAN IFAULT AVG I(VS) FROM 1m TO 2m
.meas TRAN I2T_1MS INTEG V(isq) FROM 0 TO 1m
.meas TRAN I2T_2MS INTEG V(isq) FROM 0 TO 2m
.meas TRAN I2T_5MS INTEG V(isq) FROM 0 TO 5m
.meas TRAN I2T_10MS INTEG V(isq) FROM 0 TO 10m
.meas TRAN ETVS_5MS INTEG V(ptvs) FROM 0 TO 5m
.meas TRAN ERBR_5MS INTEG V(pr) FROM 0 TO 5m
.end
