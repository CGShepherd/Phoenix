* Project Phoenix - Architecture C preregulator BJT-gain diagnostic
* Purpose: reconcile Zener-feed current against transistor base current and
*          test sensitivity to simplified pass-transistor forward gain.
* Raw rails: +/-48..60 V. 100 Hz ripple parameterised.
*
* IMPORTANT:
* - This is a diagnostic extension of PHX_ARCH_C_initial.cir.
* - LM317/LM337 remain behavioural post-regulators.
* - BZX55C24 remains a simplified parameterised model.
* - BF sweep is a sensitivity test, not a substitute for validated vendor
*   TIP41C/TIP42C models.

.param VRAW=55
.param RIPPLE=2
.param FLINE=100

* Zener feed network
.param RZ=3.9k
.param CZ=47u

* THAT1206 external receiver load
.param ILOAD=4.7m

* LM317/LM337 programming network
.param VREF=1.25
.param RSET=120
.param IPROG={VREF/RSET}

* Approximate regulator internal-current allowance.
.param IREG=0

* BZX55C24 tolerance parameter
.param VZ=24

* Simplified pass-transistor forward-gain sensitivity parameter
.param BFBJT=35

VRAW_P rawp 0 SINE({VRAW} {RIPPLE} {FLINE})
VRAW_N rawn 0 SINE({-VRAW} {RIPPLE} {FLINE})

* Positive preregulator
RZP rawp zbp {RZ}
DZP 0 zbp DZ24
CZP zbp 0 {CZ}
QPASS_P rawp zbp prep TIP41C_P

* Negative preregulator
RZN rawn zbn {RZ}
DZN zbn 0 DZ24
CZN zbn 0 {CZ}
QPASS_N rawn zbn pren TIP42C_P

* Behavioural post-regulators
BREGP outp 0 V=if(V(prep)>19.5,17,max(0,V(prep)-2.5))
BREGN outn 0 V=if(V(pren)<-19.5,-17,min(0,V(pren)+2.5))

* THAT1206 receiver loads at the regulated outputs
IP_LOAD outp 0 {ILOAD}
IN_LOAD 0 outn {ILOAD}

* Explicit preregulator-current representation
IP_PRE prep 0 {ILOAD+IPROG+IREG}
IN_PRE 0 pren {ILOAD+IPROG+IREG}

* First-pass BZX55C24 approximation
.model DZ24 D(BV={VZ} IBV=5m RS=1 N=1.2 CJO=200p)

* Simplified pass-transistor models.
* BF is swept solely to expose Zener-feed sensitivity to transistor gain.
.model TIP41C_P NPN(IS=1e-12 BF={BFBJT} VAF=75 IKF=1 CJE=300p CJC=150p)
.model TIP42C_P PNP(IS=1e-12 BF={BFBJT} VAF=75 IKF=1 CJE=300p CJC=150p)

* Operating-corner and BJT-gain sweep: 3 x 4 x 3 x 3 = 108 steps
.step param VRAW list 48 55 60
.step param ILOAD list 0 4.7m 8m 10m
.step param VZ list 22.8 24 25.6
.step param BFBJT list 15 35 75

* Retain full transient record for absolute .meas windows
.tran 0 300m 0 20u startup

* Existing preregulator measurements
.meas TRAN PREP_AVG AVG V(prep) FROM 250m TO 300m
.meas TRAN PREN_AVG AVG V(pren) FROM 250m TO 300m
.meas TRAN IZP_AVG AVG -I(DZP) FROM 250m TO 300m
.meas TRAN IZN_AVG AVG -I(DZN) FROM 250m TO 300m
.meas TRAN IQP_AVG AVG Ic(QPASS_P) FROM 250m TO 300m
.meas TRAN IQN_AVG AVG -Ic(QPASS_N) FROM 250m TO 300m

* Diagnostic feed-resistor currents.
* Positive RZP current is rawp -> zbp; negative RZN current is reported
* as a magnitude using the opposite SPICE reference direction.
.meas TRAN IRZP_AVG AVG I(RZP) FROM 250m TO 300m
.meas TRAN IRZN_AVG AVG -I(RZN) FROM 250m TO 300m

* Diagnostic transistor base-current magnitudes.
.meas TRAN IBP_AVG AVG Ib(QPASS_P) FROM 250m TO 300m
.meas TRAN IBN_AVG AVG -Ib(QPASS_N) FROM 250m TO 300m

* Direct KCL residuals at the Zener/base nodes.
* Ideal steady-state result is near zero apart from capacitor ripple current
* and numerical/model effects.
.meas TRAN KCLP_AVG PARAM IRZP_AVG-IZP_AVG-IBP_AVG
.meas TRAN KCLN_AVG PARAM IRZN_AVG-IZN_AVG-IBN_AVG

.end
