* Project Phoenix - Architecture C Stage 3 batch verification
* Requires locally prepared TI LTspice compatibility libraries:
*   models/ti/ltspice/LM317_TRANS_LTSPICE.LIB
*   models/ti/ltspice/LM337_N_TRANS_LTSPICE.LIB

* TEST 03N: negative pass-transistor C-E short with delayed crowbar action.
.param VRAW=60 RIPPLE=2 FLINE=100 RFUSE=5.5 RBR=100 ILOAD=10m
.param DELAY=200u
VRAW src 0 SINE({-VRAW} {RIPPLE} {FLINE})
RFUSE src raw 5.5
RBR raw cp {RBR}
RZ cp zb 3.6k
DZ zb 0 DZ24
CZ zb 0 47u
QPASS cp zb prep TIP42C_BOUNDED
VFAULT fctl 0 PULSE(0 1 100m 1u 1u 80m 300m)
SFAULT cp prep fctl 0 SWFAULT
VCROW cctl 0 PULSE(0 1 {100m+DELAY} 1u 1u 80m 300m)
SCROW 0 regin cctl 0 SWCROW
VSENSE prep regin 0

R1 out adj 120
R2 adj 0 1.50k
COUT 0 out 10u
ILOAD 0 out {ILOAD}
.include "models/ti/ltspice/LM337_N_TRANS_LTSPICE.LIB"
XU regin adj out LM337_N_TRANS
.model DZ24 D(BV=24 IBV=5m RS=1 N=1.2 CJO=200p)
.model TIP42C_BOUNDED PNP(IS=1e-12 BF=15 VAF=75 IKF=1 CJE=300p CJC=150p)
.model SWFAULT SW(Ron=0.02 Roff=1G Vt=0.5 Vh=0.1)
.model SWCROW SW(Ron=0.05 Roff=1G Vt=0.5 Vh=0.1)

.step param DELAY list 50u 200u 1m
.tran 0 130m 0 1u startup
.meas TRAN DIFF_MAX MAX V(out,regin) FROM 100m TO 105m
.meas TRAN VIN_MAG_MAX MAX -V(regin) FROM 100m TO 105m
.meas TRAN IFUSE_MAG_MAX MAX -I(RFUSE) FROM 100m TO 105m
.meas TRAN OUT_MAG_MIN MIN -V(out) FROM 100m TO 110m
.end
