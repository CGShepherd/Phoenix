* Project Phoenix - Architecture C Stage 3B consolidated verification
* Requires:
*   models/ti/ltspice/LM317_TRANS_LTSPICE.LIB
*   models/ti/ltspice/LM337_N_TRANS_LTSPICE.LIB

* TEST 05: both one-rail-loss directions.
.param WHICH=1 ILOAD=10m RFUSE=5.5 RBR=100
* WHICH=1 => lose negative rail, WHICH=2 => lose positive rail.
BVP srcp 0 V={if(WHICH==2, if(time<100m,60,0),60)}
BVN srcn 0 V={if(WHICH==1, if(time<100m,-60,0),-60)}

RFUSEP srcp rawp {RFUSE}
RFUSEN srcn rawn {RFUSE}
RBRP rawp cp {RBR}
RBRN rawn cn {RBR}
RZP cp zbp 3.6k
DZP 0 zbp DZ24
CZP zbp 0 47u
QPP cp zbp prep TIP41C_BOUNDED
RZN cn zbn 3.6k
DZN zbn 0 DZ24
CZN zbn 0 47u
QPN cn zbn pren TIP42C_BOUNDED

R1P outp adjp 120
R2P adjp 0 1.50k
R1N outn adjn 120
R2N adjn 0 1.50k
COUTP outp 0 10u
COUTN 0 outn 10u
IP outp 0 {ILOAD}
IN 0 outn {ILOAD}

.include "models/ti/ltspice/LM317_TRANS_LTSPICE.LIB"
.include "models/ti/ltspice/LM337_N_TRANS_LTSPICE.LIB"
XUP prep adjp outp nc317 LM317_TRANS
XUN pren adjn outn LM337_N_TRANS
.model DZ24 D(BV=24 IBV=5m RS=1 N=1.2 CJO=200p)
.model TIP41C_BOUNDED NPN(IS=1e-12 BF=15 VAF=75 IKF=1 CJE=300p CJC=150p)
.model TIP42C_BOUNDED PNP(IS=1e-12 BF=15 VAF=75 IKF=1 CJE=300p CJC=150p)

.step param WHICH list 1 2
.tran 0 220m 0 5u startup
.meas TRAN POS_BEFORE AVG V(outp) FROM 70m TO 95m
.meas TRAN NEG_BEFORE AVG V(outn) FROM 70m TO 95m
.meas TRAN POS_AFTER AVG V(outp) FROM 160m TO 200m
.meas TRAN NEG_AFTER AVG V(outn) FROM 160m TO 200m
.meas TRAN POS_EVENT_MAX MAX V(outp) FROM 95m TO 130m
.meas TRAN POS_EVENT_MIN MIN V(outp) FROM 95m TO 130m
.meas TRAN NEG_EVENT_MAX MAX V(outn) FROM 95m TO 130m
.meas TRAN NEG_EVENT_MIN MIN V(outn) FROM 95m TO 130m
.end
