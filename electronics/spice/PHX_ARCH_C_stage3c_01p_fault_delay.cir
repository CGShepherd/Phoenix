* Project Phoenix - Architecture C Stage 3C protection closure
* Destructive-fault decks deliberately exclude TI regulator macromodels.
* Regulator safety is evaluated against a 40 V input-output differential limit.

* TEST 01P: positive pass-short with physical source/fuse/RBR/crowbar network.
* Regulator is represented only by a 17 V output reference for differential exposure.
.param VRAW=60 RFUSE=5.5 RBR=100 VOUT=17 DELAY=200u

VRAW src 0 {VRAW}
RFUSE src raw {RFUSE}
RBR raw regin {RBR}

* Fault occurs at 100 ms; crowbar action occurs after DELAY.
VC ctl 0 PULSE(0 1 {100m+DELAY} 1u 1u 20m 300m)
SCROW regin 0 ctl 0 SWC
.model SWC SW(Ron=0.05 Roff=1G Vt=0.5 Vh=0.1)

* Small preload emulates regulator/program network before crowbar.
RLOAD regin 0 2.4k

.step param DELAY list 10u 25u 50u 100u 200u 500u 1m 2m 5m
.tran 0 110m 0 0.5u

.meas TRAN VIN_PRE_MAX MAX V(regin) FROM 100m TO {100m+DELAY}
.meas TRAN DIFF_PRE_MAX PARAM VIN_PRE_MAX-VOUT
.meas TRAN IFUSE_MAX MAX I(RFUSE) FROM {100m+DELAY} TO {100m+DELAY+1m}

BISQ isq 0 V={I(RFUSE)*I(RFUSE)}
.meas TRAN I2T_0P5MS INTEG V(isq) FROM {100m+DELAY} TO {100m+DELAY+0.5m}
.meas TRAN I2T_1MS INTEG V(isq) FROM {100m+DELAY} TO {100m+DELAY+1m}
.meas TRAN I2T_2MS INTEG V(isq) FROM {100m+DELAY} TO {100m+DELAY+2m}

BPR pbr 0 V={V(raw,regin)*I(RFUSE)}
.meas TRAN ERBR_0P5MS INTEG V(pbr) FROM {100m+DELAY} TO {100m+DELAY+0.5m}
.meas TRAN ERBR_1MS INTEG V(pbr) FROM {100m+DELAY} TO {100m+DELAY+1m}
.meas TRAN PRBR_MAX MAX V(pbr) FROM {100m+DELAY} TO {100m+DELAY+1m}
.end
