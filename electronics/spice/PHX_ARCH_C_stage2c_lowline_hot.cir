* Project Phoenix - Architecture C Stage 2C low-line hot-Zener decision sweep
* Purpose: determine minimum Zener current at low raw rail / high load when
*          BZX55C24 positive temperature coefficient raises effective VZ.
*
* This is a bounded sensitivity deck, not a complete electrothermal model.
* Effective VZ is calculated from a typical datasheet temperature coefficient
* TCVZ = 7.5e-4 /K. VZ25 is still swept across the 25 C tolerance range.
*
* Compare only RZ = 3.6k and 3.3k.

.param VRAW=48
.param RIPPLE=2
.param FLINE=100
.param ILOAD=10m
.param RZ=3.6k
.param CZ=47u
.param VZ25=24
.param TDEV=25
.param TCVZ=7.5e-4
.param VZEFF={VZ25*(1+TCVZ*(TDEV-25))}
.param BFBJT=15

VRAW_P rawp 0 SINE({VRAW} {RIPPLE} {FLINE})
VRAW_N rawn 0 SINE({-VRAW} {RIPPLE} {FLINE})

RZP rawp zbp {RZ}
DZP 0 zbp DZ24
CZP zbp 0 {CZ}
QPASS_P rawp zbp prep TIP41C_BOUNDED
RZN rawn zbn {RZ}
DZN zbn 0 DZ24
CZN zbn 0 {CZ}
QPASS_N rawn zbn pren TIP42C_BOUNDED

VSENSEP prep reginp 0
VSENSEN pren reginn 0
R1P outp adjp 120
R2P adjp 0 1.50k
R1N outn adjn 120
R2N adjn 0 1.50k
COUTP outp 0 10u
COUTN 0 outn 10u
IP_LOAD outp 0 {ILOAD}
IN_LOAD 0 outn {ILOAD}

.include "models/ti/ltspice/LM317_TRANS_LTSPICE.LIB"
.include "models/ti/ltspice/LM337_N_TRANS_LTSPICE.LIB"
XU317 reginp adjp outp nc317 LM317_TRANS
XU337 reginn adjn outn LM337_N_TRANS

.model DZ24 D(BV={VZEFF} IBV=5m RS=1 N=1.2 CJO=200p)
.model TIP41C_BOUNDED NPN(IS=1e-12 BF={BFBJT} VAF=75 IKF=1 CJE=300p CJC=150p)
.model TIP42C_BOUNDED PNP(IS=1e-12 BF={BFBJT} VAF=75 IKF=1 CJE=300p CJC=150p)

.step param RZ list 3.6k 3.3k
.step param VZ25 list 22.8 24 25.6
.step param TDEV list 25 60 85

.tran 0 300m 0 20u startup

.meas TRAN VZEFF_CALC PARAM VZEFF
.meas TRAN PREP_AVG AVG V(prep) FROM 250m TO 300m
.meas TRAN OUTP_AVG AVG V(outp) FROM 250m TO 300m
.meas TRAN DROP_P_MIN MIN V(prep,outp) FROM 250m TO 300m
.meas TRAN IZP_AVG AVG -I(DZP) FROM 250m TO 300m
.meas TRAN IZN_AVG AVG -I(DZN) FROM 250m TO 300m
.meas TRAN IRZP_AVG AVG I(RZP) FROM 250m TO 300m
.meas TRAN IBP_AVG AVG Ib(QPASS_P) FROM 250m TO 300m

.end
