* Project Phoenix PHX-202 negative preregulator Rev F2
* Physical nominal core-loop screening.
* TRUE NEGATIVE RAILS: V(out) should regulate to about -18.10 V.
* Self-contained LT1636 screening surrogate; BJTs and optocoupler have explicit junction/capacitance models.

.param VRAW=55
.param COUT=10u
.param CTR=1.0
.param ILOAD1=4.7m
.param ILOAD2=8m
.param VSET=18.10
.param VCB=18.71
.param OPTOBF=100

* Core supplies. Controller/reference are idealised in Rev F2 to isolate the core loop.
VRAW_SRC raw 0 PULSE(0 {-VRAW} 1m 2m 2m 1 2)
VAUX aux 0 -18
VREF ref 0 -2.5

* Load: 4.7 mA initially, rising to 8.0 mA at 120 ms.
ILOAD 0 out PWL(0 {ILOAD1} 119.9m {ILOAD1} 120m {ILOAD2})
COUT1 out 0 {COUT} Rser=0.20

* Actual-output sensing: -18.10 V at out gives approximately -2.50 V at sense.
RFB_OUT out sense 311.4k
RFB_GND sense 0 49.9k

* LT1636 surrogate: + input at -2.5 V reference, - input at output sense.
* Supply rails are 0 V and -18 V. Parameters approximate LT1636 headline values.
* Self-contained bounded controller surrogate.
* BERR provides finite high DC gain with output limits inside the 0/-18 V rails.
* RERR/CERR impose approximately 220 kHz command-node bandwidth without a hidden integrator.
BERR err 0 V=limit(200k*(V(ref)-V(sense)),-17.95,-0.05)
RERR err cmd 1k
CERR cmd 0 723p
RCMD cmd 0 100Meg

* LED drive: op-amp sinks current when cmd goes negative.
RLED 0 led_a 30.1k
VLED_SENSE led_a led_k 0
DLED led_k cmd DOPTOLED

* Optocoupler phototransistor. Photocurrent is injected into its base;
* QOPTO provides real B-E/C-B junctions and capacitances.
R_OPTO out opto_c 100k
QOPTO opto_c opto_b drv_b QOPTNPN
FPHOTO opto_b drv_b VLED_SENSE {CTR/OPTOBF}
R_OPTO_BLEED opto_b drv_b 100Meg

* High-voltage NPN driver, default off through RBE2.
QDRV drv_c drv_b raw QMPSA42
RBE2 drv_b raw 47k
RDRIVE drv_c pass_b 24.9k

* PNP pass transistor, default off through RBE1.
QPASS raw pass_b out QMJE350
RBE1 pass_b out 10k

* Measurement-only magnitude node.
BMAG mag 0 V=-V(out)

* Approximate physical models for core-loop screening.
.model DOPTOLED D(Is=2n N=1.9 Rs=8 Cjo=18p M=0.35 Tt=1u Bv=6 Ibv=10u)
.model QOPTNPN NPN(Is=5p Bf={OPTOBF} Vaf=40 Ikf=5m Br=3 Cje=35p Cjc=8p Tf=12u Tr=25u)
.model QMPSA42 NPN(Is=20f Bf=60 Vaf=80 Ikf=25m Br=4 Cje=18p Cjc=4p Tf=0.35u Tr=2u Ise=2p Ne=1.7)
.model QMJE350 PNP(Is=80f Bf=50 Vaf=70 Ikf=100m Br=5 Cje=60p Cjc=25p Tf=0.8u Tr=5u Ise=8p Ne=1.6)

.options plotwinsize=0 reltol=1e-4 abstol=1n vntol=1u
.tran 0 260m 0 2u startup

* Operating and transient measurements.
.meas tran VPEAKSTART MAX V(mag) FROM=0 TO=119m
.meas tran VPRE FIND V(mag) AT=110m
.meas tran T90 WHEN V(mag)=16.29 RISE=1
.meas tran VMINSTEP MIN V(mag) FROM=120m TO=200m
.meas tran VMAXSTEP MAX V(mag) FROM=120m TO=200m
.meas tran VPOST FIND V(mag) AT=250m
.meas tran STARTCROWBAR PARAM='VPEAKSTART>VCB'
.meas tran ANYCROWBAR PARAM='max(VPEAKSTART,VMAXSTEP)>VCB'

* Useful device-current measurements at nominal settled points.
.meas tran ILED_PRE FIND -I(VLED_SENSE) AT=110m
.meas tran ILED_POST FIND -I(VLED_SENSE) AT=250m
.meas tran IPASS_PRE FIND Ic(QPASS) AT=110m
.meas tran IPASS_POST FIND Ic(QPASS) AT=250m
.meas tran VCMD_PRE FIND V(cmd) AT=110m
.meas tran VCMD_POST FIND V(cmd) AT=250m
.end
